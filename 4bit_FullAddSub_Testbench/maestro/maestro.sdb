ADE simulation setup
Run mode: Single Run, Sweeps and Corners
Tests:
  Group2_VLSI_EE5900_4bit_FullAddSub_Testbench_1: Group2_VLSI_EE5900/4bit_FullAddSub_Testbench/schematic, simulator spectre
