ADE simulation setup
Test Group2_VLSI_EE5900_4bit_FullAddSub_Testbench_1: Group2_VLSI_EE5900/4bit_FullAddSub_Testbench/schematic, simulator spectre
  Models: /opt/cadence-suite/sky130_release_0.0.4/libs/sky130_fd_pr_main/../../models/sky130.lib.spice[tt], /opt/cadence-suite/ncsu/models/spectre/nom/ami06N.m, /opt/cadence-suite/ncsu/models/spectre/nom/ami06P.m, /opt/cadence-suite/ncsu/models/spectre/nom/ami16N.m, /opt/cadence-suite/ncsu/models/spectre/nom/ami16P.m, /opt/cadence-suite/ncsu/models/spectre/nom/hp10N.m, /opt/cadence-suite/ncsu/models/spectre/nom/hp10P.m, /opt/cadence-suite/ncsu/models/spectre/nom/hp14tbN.m, /opt/cadence-suite/ncsu/models/spectre/nom/hp14tbP.m, /opt/cadence-suite/ncsu/models/spectre/nom/tsmc35N.m.n88y, /opt/cadence-suite/ncsu/models/spectre/nom/tsmc35P.m.n88y
  Temperature: 27
  Analysis tran: stop=6u errpreset=moderate
  Signals: /A<0>, /A<1>, /A<2>, /A<3>, /B<0>, /B<1>, /B<2>, /B<3>, /net1, /S<0>, /S<1>, /S<2>, /S<3>, /Cout
Run mode: Single Run, Sweeps and Corners
