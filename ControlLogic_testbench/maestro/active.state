ADE simulation setup
Test Group2_VLSI_EE5900_ControlLogic_testbench_1: Group2_VLSI_EE5900/ControlLogic_testbench/schematic, simulator spectre
  Models: /opt/cadence-suite/sky130_release_0.0.4/libs/sky130_fd_pr_main/../../models/sky130.lib.spice[tt], /opt/cadence-suite/ncsu/models/spectre/nom/ami06N.m, /opt/cadence-suite/ncsu/models/spectre/nom/ami06P.m, /opt/cadence-suite/ncsu/models/spectre/nom/ami16N.m, /opt/cadence-suite/ncsu/models/spectre/nom/ami16P.m, /opt/cadence-suite/ncsu/models/spectre/nom/hp10N.m, /opt/cadence-suite/ncsu/models/spectre/nom/hp10P.m, /opt/cadence-suite/ncsu/models/spectre/nom/hp14tbN.m, /opt/cadence-suite/ncsu/models/spectre/nom/hp14tbP.m, /opt/cadence-suite/ncsu/models/spectre/nom/tsmc35N.m.n88y, /opt/cadence-suite/ncsu/models/spectre/nom/tsmc35P.m.n88y
  Temperature: 27
  Analysis tran: stop=200n errpreset=moderate
  Signals: /IN<0>, /IN<1>, /IN<2>, /IN<3>, /AND_OR, /Shift, /Mem, /Adder, /SUB_ADD, /L_R, /MemCLK
Run mode: Single Run, Sweeps and Corners
