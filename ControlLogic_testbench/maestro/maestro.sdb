ADE simulation setup
Run mode: Single Run, Sweeps and Corners
Tests:
  Group2_VLSI_EE5900_ControlLogic_testbench_1: Group2_VLSI_EE5900/ControlLogic_testbench/schematic, simulator spectre
