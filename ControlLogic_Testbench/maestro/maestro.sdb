ADE simulation setup
Run mode: Single Run, Sweeps and Corners
Tests:
  Group2_VLSI_EE5900_ControlLogic_Testbench_1: Group2_VLSI_EE5900/ControlLogic_Testbench/schematic, simulator spectre
