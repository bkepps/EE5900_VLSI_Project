* +++++++++++++++++++++++++++++++++++++++++++++++++++++++++ *
* CDL Netlist:                                              *
*                                                           *
* Cell Name  : Barrel_Shifter                               *
* Netlisted  : Sun Dec  7 19:27:25 2025                     *
* Pegasus Version: 23.14-s006 Thu Jan 25 18:41:38 PST 2024  *
* +++++++++++++++++++++++++++++++++++++++++++++++++++++++++ *
*.LDD
*.DEVTMPLT 0 R(res_generic_m1) met1_res met1(P) met1(N)
*.DEVTMPLT 1 R(res_generic_m2) met2_res met2(P) met2(N)
*.DEVTMPLT 2 R(res_generic_m3) met3_res met3(P) met3(N)
*.DEVTMPLT 3 R(res_generic_m4) met4_res met4(P) met4(N)
*.DEVTMPLT 4 R(res_generic_m5) met5_res met5(P) met5(N)
*.DEVTMPLT 5 R(RES_GENERIC_ND) diff_res np_term(P) np_term(N)
*.DEVTMPLT 6 R(RES_GENERIC_PD) diff_res pp_term(P) pp_term(N)
*.DEVTMPLT 7 MN(nfet_01v8) nfet_01v8_rec nSourceDrain(D) nfet(G) nSourceDrain(S) pwell(B)
*.DEVTMPLT 8 MP(pfet_01v8) pfet_01v8_rec pSourceDrain(D) pfet(G) pSourceDrain(S) nwell(B)

* +++++++++++++++++++++++++++++++++++++++++++++++++++++++++ *
* Sub cell: pfet_01v8_CDNS_765153643593                     *
* +++++++++++++++++++++++++++++++++++++++++++++++++++++++++ *
.subckt pfet_01v8_CDNS_765153643593 1 2 3
** N=5 EP=3 FDC=1
M0 2 3 1 1 pfet_01v8 L=1.5e-07 W=5.5e-07 $X=0 $Y=0 $dt=8
.ends pfet_01v8_CDNS_765153643593

* +++++++++++++++++++++++++++++++++++++++++++++++++++++++++ *
* Sub cell: nfet_01v8_CDNS_765153643594                     *
* +++++++++++++++++++++++++++++++++++++++++++++++++++++++++ *
.subckt nfet_01v8_CDNS_765153643594 1 2 3
** N=5 EP=3 FDC=1
M0 2 3 1 1 nfet_01v8 L=1.5e-07 W=4.2e-07 $X=0 $Y=0 $dt=7
.ends nfet_01v8_CDNS_765153643594

* +++++++++++++++++++++++++++++++++++++++++++++++++++++++++ *
* Sub cell: NOT                                             *
* +++++++++++++++++++++++++++++++++++++++++++++++++++++++++ *
.subckt NOT 1 2 3 4
** N=4 EP=4 FDC=2
X5 2 4 1 pfet_01v8_CDNS_765153643593 $T=710 1880 0 0 $X=265 $Y=1700
X6 3 4 1 nfet_01v8_CDNS_765153643594 $T=710 650 0 0 $X=305 $Y=500
.ends NOT

* +++++++++++++++++++++++++++++++++++++++++++++++++++++++++ *
* Sub cell: nfet_01v8_CDNS_765153643595                     *
* +++++++++++++++++++++++++++++++++++++++++++++++++++++++++ *
.subckt nfet_01v8_CDNS_765153643595 1 2 3 4
** N=6 EP=4 FDC=1
M0 1 4 2 3 nfet_01v8 L=1.5e-07 W=4.2e-07 $X=0 $Y=0 $dt=7
.ends nfet_01v8_CDNS_765153643595

* +++++++++++++++++++++++++++++++++++++++++++++++++++++++++ *
* Sub cell: nfet_01v8_CDNS_765153643596                     *
* +++++++++++++++++++++++++++++++++++++++++++++++++++++++++ *
.subckt nfet_01v8_CDNS_765153643596 1 2 3
** N=4 EP=3 FDC=1
M0 2 3 1 1 nfet_01v8 L=1.5e-07 W=4.2e-07 $X=0 $Y=0 $dt=7
.ends nfet_01v8_CDNS_765153643596

* +++++++++++++++++++++++++++++++++++++++++++++++++++++++++ *
* Sub cell: pfet_01v8_CDNS_765153643597                     *
* +++++++++++++++++++++++++++++++++++++++++++++++++++++++++ *
.subckt pfet_01v8_CDNS_765153643597 1 2 3
** N=5 EP=3 FDC=1
M0 2 3 1 1 pfet_01v8 L=1.5e-07 W=5.5e-07 $X=0 $Y=0 $dt=8
.ends pfet_01v8_CDNS_765153643597

* +++++++++++++++++++++++++++++++++++++++++++++++++++++++++ *
* Sub cell: pfet_01v8_CDNS_765153643598                     *
* +++++++++++++++++++++++++++++++++++++++++++++++++++++++++ *
.subckt pfet_01v8_CDNS_765153643598 1 2 3
** N=5 EP=3 FDC=1
M0 1 3 2 2 pfet_01v8 L=1.5e-07 W=5.5e-07 $X=0 $Y=0 $dt=8
.ends pfet_01v8_CDNS_765153643598

* +++++++++++++++++++++++++++++++++++++++++++++++++++++++++ *
* Sub cell: NAND                                            *
* +++++++++++++++++++++++++++++++++++++++++++++++++++++++++ *
.subckt NAND 1 2 3 4 5
** N=6 EP=5 FDC=4
X5 5 6 4 1 nfet_01v8_CDNS_765153643595 $T=1430 1420 0 180 $X=875 $Y=220
X6 4 6 2 nfet_01v8_CDNS_765153643596 $T=1790 1420 0 180 $X=1525 $Y=850
X7 3 5 1 pfet_01v8_CDNS_765153643597 $T=850 2510 0 0 $X=405 $Y=2330
X8 5 3 2 pfet_01v8_CDNS_765153643598 $T=1430 3060 0 180 $X=1045 $Y=2330
.ends NAND

* +++++++++++++++++++++++++++++++++++++++++++++++++++++++++ *
* Sub cell: AND                                             *
* +++++++++++++++++++++++++++++++++++++++++++++++++++++++++ *
.subckt AND 1 2 3 4 5
** N=6 EP=5 FDC=6
X0 6 3 4 5 NOT $T=2360 0 0 0 $X=2360 $Y=0
X1 2 1 3 4 6 NAND $T=0 0 0 0 $X=0 $Y=0
.ends AND

* +++++++++++++++++++++++++++++++++++++++++++++++++++++++++ *
* Sub cell: AND3                                            *
* +++++++++++++++++++++++++++++++++++++++++++++++++++++++++ *
.subckt AND3 C B Vdd A Vss Vout
** N=7 EP=6 FDC=12
X0 B A Vdd Vss 7 AND $T=0 0 0 0 $X=0 $Y=0
X1 C 7 Vdd Vss Vout AND $T=4150 0 0 0 $X=4150 $Y=0
.ends AND3

* +++++++++++++++++++++++++++++++++++++++++++++++++++++++++ *
* Sub cell: nfet_01v8_CDNS_765153643599                     *
* +++++++++++++++++++++++++++++++++++++++++++++++++++++++++ *
.subckt nfet_01v8_CDNS_765153643599 1 2 3
** N=4 EP=3 FDC=1
M0 2 3 1 1 nfet_01v8 L=1.5e-07 W=4.2e-07 $X=0 $Y=0 $dt=7
.ends nfet_01v8_CDNS_765153643599

* +++++++++++++++++++++++++++++++++++++++++++++++++++++++++ *
* Sub cell: pfet_01v8_CDNS_7651536435910                    *
* +++++++++++++++++++++++++++++++++++++++++++++++++++++++++ *
.subckt pfet_01v8_CDNS_7651536435910 1 2 3 4
** N=5 EP=4 FDC=1
M0 2 3 1 4 pfet_01v8 L=1.5e-07 W=5.5e-07 $X=0 $Y=0 $dt=8
.ends pfet_01v8_CDNS_7651536435910

* +++++++++++++++++++++++++++++++++++++++++++++++++++++++++ *
* Sub cell: pfet_01v8_CDNS_7651536435911                    *
* +++++++++++++++++++++++++++++++++++++++++++++++++++++++++ *
.subckt pfet_01v8_CDNS_7651536435911 1 2 3
** N=4 EP=3 FDC=1
M0 2 3 1 1 pfet_01v8 L=1.5e-07 W=5.5e-07 $X=0 $Y=0 $dt=8
.ends pfet_01v8_CDNS_7651536435911

* +++++++++++++++++++++++++++++++++++++++++++++++++++++++++ *
* Sub cell: nfet_01v8_CDNS_7651536435912                    *
* +++++++++++++++++++++++++++++++++++++++++++++++++++++++++ *
.subckt nfet_01v8_CDNS_7651536435912 1 2 3
** N=5 EP=3 FDC=1
M0 2 3 1 1 nfet_01v8 L=1.5e-07 W=4.2e-07 $X=0 $Y=0 $dt=7
.ends nfet_01v8_CDNS_7651536435912

* +++++++++++++++++++++++++++++++++++++++++++++++++++++++++ *
* Sub cell: NOR                                             *
* +++++++++++++++++++++++++++++++++++++++++++++++++++++++++ *
.subckt NOR 1 2 3 4 5
** N=6 EP=5 FDC=4
X5 4 5 2 nfet_01v8_CDNS_765153643599 $T=1300 1370 0 180 $X=1085 $Y=800
X6 6 5 1 3 pfet_01v8_CDNS_7651536435910 $T=1300 3010 0 180 $X=705 $Y=2280
X7 3 6 2 pfet_01v8_CDNS_7651536435911 $T=1660 3010 0 180 $X=1225 $Y=2280
X8 4 5 1 nfet_01v8_CDNS_7651536435912 $T=720 950 0 0 $X=315 $Y=800
.ends NOR

* +++++++++++++++++++++++++++++++++++++++++++++++++++++++++ *
* Sub cell: OR4                                             *
* +++++++++++++++++++++++++++++++++++++++++++++++++++++++++ *
.subckt OR4 1 2 3 4 5 6 7
** N=12 EP=7 FDC=18
X4 9 6 5 10 NOT $T=2350 580 0 0 $X=2350 $Y=580
X5 11 6 5 8 NOT $T=2350 6990 1 0 $X=2350 $Y=3630
X6 12 6 5 7 NOT $T=6060 800 0 0 $X=6060 $Y=800
X7 4 1 6 5 9 NOR $T=0 0 0 0 $X=0 $Y=0
X8 3 2 6 5 11 NOR $T=0 7560 1 0 $X=0 $Y=3560
X9 10 8 6 5 12 NOR $T=3710 420 0 0 $X=3710 $Y=420
.ends OR4

* +++++++++++++++++++++++++++++++++++++++++++++++++++++++++ *
* Sub cell: 4_1_MUX_Schematic                               *
* +++++++++++++++++++++++++++++++++++++++++++++++++++++++++ *
.subckt 4_1_MUX_Schematic A S1 S0 Vdd B C D Vss Vout
** N=15 EP=9 FDC=70
X29 S1 Vdd Vss 11 NOT $T=430 13610 0 0 $X=430 $Y=13610
X30 S0 Vdd Vss 10 NOT $T=3290 13610 0 0 $X=3290 $Y=13610
X31 S0 S1 Vdd D Vss 12 AND3 $T=5630 100 0 0 $X=5630 $Y=100
X32 10 S1 Vdd C Vss 13 AND3 $T=5630 4380 0 0 $X=5630 $Y=4380
X33 S0 11 Vdd B Vss 14 AND3 $T=5630 8690 0 0 $X=5630 $Y=8690
X34 10 11 Vdd A Vss 15 AND3 $T=5630 12960 0 0 $X=5630 $Y=12960
X35 12 14 15 13 Vss Vdd Vout OR4 $T=15100 9410 0 0 $X=15100 $Y=9410
.ends 4_1_MUX_Schematic

* +++++++++++++++++++++++++++++++++++++++++++++++++++++++++ *
* Sub cell: Barrel_Shifter                                  *
* +++++++++++++++++++++++++++++++++++++++++++++++++++++++++ *
.subckt Barrel_Shifter S0 S1 Vdd Vss W0 W1 W2 W3 Y0 Y1
+ Y2 Y3
** N=16 EP=12 FDC=280
X78 W3 S1 S0 Vdd W0 W1 W2 Vss Y3 4_1_MUX_Schematic $T=2730 1560 0 0 $X=2730 $Y=1570
X79 W2 S1 S0 Vdd W3 W0 W1 Vss Y2 4_1_MUX_Schematic $T=28300 1490 0 0 $X=28300 $Y=1500
X80 W1 S1 S0 Vdd W2 W3 W0 Vss Y1 4_1_MUX_Schematic $T=53890 1570 0 0 $X=53890 $Y=1580
X81 14 S1 S0 Vdd 15 16 W3 Vss Y0 4_1_MUX_Schematic $T=79160 1590 0 0 $X=79160 $Y=1600
.ends Barrel_Shifter
