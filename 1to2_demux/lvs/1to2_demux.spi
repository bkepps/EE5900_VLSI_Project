* +++++++++++++++++++++++++++++++++++++++++++++++++++++++++ *
* CDL Netlist:                                              *
*                                                           *
* Cell Name  : 1to2_demux                                   *
* Netlisted  : Wed Dec  3 18:46:59 2025                     *
* Pegasus Version: 23.14-s006 Thu Jan 25 18:41:38 PST 2024  *
* +++++++++++++++++++++++++++++++++++++++++++++++++++++++++ *
*.LDD
*.DEVTMPLT 0 R(res_generic_m1) met1_res met1(P) met1(N)
*.DEVTMPLT 1 R(res_generic_m2) met2_res met2(P) met2(N)
*.DEVTMPLT 2 R(res_generic_m3) met3_res met3(P) met3(N)
*.DEVTMPLT 3 R(res_generic_m4) met4_res met4(P) met4(N)
*.DEVTMPLT 4 R(res_generic_m5) met5_res met5(P) met5(N)
*.DEVTMPLT 5 R(RES_GENERIC_ND) diff_res np_term(P) np_term(N)
*.DEVTMPLT 6 R(RES_GENERIC_PD) diff_res pp_term(P) pp_term(N)
*.DEVTMPLT 7 MN(nfet_01v8) nfet_01v8_rec nSourceDrain(D) nfet(G) nSourceDrain(S) pwell(B)
*.DEVTMPLT 8 MP(pfet_01v8) pfet_01v8_rec pSourceDrain(D) pfet(G) pSourceDrain(S) nwell(B)

* +++++++++++++++++++++++++++++++++++++++++++++++++++++++++ *
* Sub cell: pfet_01v8_CDNS_764805609603                     *
* +++++++++++++++++++++++++++++++++++++++++++++++++++++++++ *
.subckt pfet_01v8_CDNS_764805609603 1 2 3
** N=5 EP=3 FDC=1
M0 2 3 1 1 pfet_01v8 L=1.5e-07 W=5.5e-07 $X=0 $Y=0 $dt=8
.ends pfet_01v8_CDNS_764805609603

* +++++++++++++++++++++++++++++++++++++++++++++++++++++++++ *
* Sub cell: nfet_01v8_CDNS_764805609604                     *
* +++++++++++++++++++++++++++++++++++++++++++++++++++++++++ *
.subckt nfet_01v8_CDNS_764805609604 1 2 3 4
** N=6 EP=4 FDC=1
M0 2 3 1 4 nfet_01v8 L=1.5e-07 W=4.2e-07 $X=0 $Y=0 $dt=7
.ends nfet_01v8_CDNS_764805609604

* +++++++++++++++++++++++++++++++++++++++++++++++++++++++++ *
* Sub cell: NOT                                             *
* +++++++++++++++++++++++++++++++++++++++++++++++++++++++++ *
.subckt NOT 1 2 3 4 5
** N=7 EP=5 FDC=2
X3 1 4 3 pfet_01v8_CDNS_764805609603 $T=710 1880 0 0 $X=265 $Y=1700
X4 2 4 3 5 nfet_01v8_CDNS_764805609604 $T=710 650 0 0 $X=305 $Y=500
.ends NOT

* +++++++++++++++++++++++++++++++++++++++++++++++++++++++++ *
* Sub cell: nfet_01v8_CDNS_764805609605                     *
* +++++++++++++++++++++++++++++++++++++++++++++++++++++++++ *
.subckt nfet_01v8_CDNS_764805609605 1 2 4 5
** N=7 EP=4 FDC=1
M0 1 4 2 5 nfet_01v8 L=1.5e-07 W=4.2e-07 $X=0 $Y=0 $dt=7
.ends nfet_01v8_CDNS_764805609605

* +++++++++++++++++++++++++++++++++++++++++++++++++++++++++ *
* Sub cell: nfet_01v8_CDNS_764805609606                     *
* +++++++++++++++++++++++++++++++++++++++++++++++++++++++++ *
.subckt nfet_01v8_CDNS_764805609606 1 2 3 4
** N=5 EP=4 FDC=1
M0 2 3 1 4 nfet_01v8 L=1.5e-07 W=4.2e-07 $X=0 $Y=0 $dt=7
.ends nfet_01v8_CDNS_764805609606

* +++++++++++++++++++++++++++++++++++++++++++++++++++++++++ *
* Sub cell: pfet_01v8_CDNS_764805609607                     *
* +++++++++++++++++++++++++++++++++++++++++++++++++++++++++ *
.subckt pfet_01v8_CDNS_764805609607 1 2 3
** N=5 EP=3 FDC=1
M0 2 3 1 1 pfet_01v8 L=1.5e-07 W=5.5e-07 $X=0 $Y=0 $dt=8
.ends pfet_01v8_CDNS_764805609607

* +++++++++++++++++++++++++++++++++++++++++++++++++++++++++ *
* Sub cell: pfet_01v8_CDNS_764805609608                     *
* +++++++++++++++++++++++++++++++++++++++++++++++++++++++++ *
.subckt pfet_01v8_CDNS_764805609608 1 2 3
** N=5 EP=3 FDC=1
M0 1 3 2 2 pfet_01v8 L=1.5e-07 W=5.5e-07 $X=0 $Y=0 $dt=8
.ends pfet_01v8_CDNS_764805609608

* +++++++++++++++++++++++++++++++++++++++++++++++++++++++++ *
* Sub cell: NAND                                            *
* +++++++++++++++++++++++++++++++++++++++++++++++++++++++++ *
.subckt NAND 1 2 3 4 5 6
** N=7 EP=6 FDC=4
X5 5 7 1 6 nfet_01v8_CDNS_764805609605 $T=1430 1420 0 180 $X=875 $Y=220
X6 4 7 2 6 nfet_01v8_CDNS_764805609606 $T=1790 1420 0 180 $X=1525 $Y=850
X7 3 5 1 pfet_01v8_CDNS_764805609607 $T=850 2510 0 0 $X=405 $Y=2330
X8 5 3 2 pfet_01v8_CDNS_764805609608 $T=1430 3060 0 180 $X=1045 $Y=2330
.ends NAND

* +++++++++++++++++++++++++++++++++++++++++++++++++++++++++ *
* Sub cell: AND                                             *
* +++++++++++++++++++++++++++++++++++++++++++++++++++++++++ *
.subckt AND 1 2 3 4 6
** N=7 EP=5 FDC=6
X0 1 4 7 5 6 NOT $T=2360 0 0 0 $X=2360 $Y=0
X1 2 3 1 4 7 6 NAND $T=0 0 0 0 $X=0 $Y=0
.ends AND

* +++++++++++++++++++++++++++++++++++++++++++++++++++++++++ *
* Sub cell: 1to2_demux                                      *
* +++++++++++++++++++++++++++++++++++++++++++++++++++++++++ *
.subckt 1to2_demux
** N=10 EP=0 FDC=16
X8 1 6 7 3 6 NOT $T=1330 5215 0 0 $X=1330 $Y=5215
X9 1 6 3 8 6 NOT $T=3835 5235 0 0 $X=3835 $Y=5235
X10 1 4 2 9 6 AND $T=6115 369 0 0 $X=6115 $Y=369
X11 1 8 2 6 6 AND $T=6140 4625 0 0 $X=6140 $Y=4625
.ends 1to2_demux
