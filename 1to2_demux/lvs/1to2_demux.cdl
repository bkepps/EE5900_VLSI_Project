*******************************************************************
* CDL Produced by pegasusBuildNetlist on Wed Dec 03 18:44:48 2025 *
*******************************************************************

* File content...

***********************************************************
* CDL produced by pvsBuildNetlist on Dec  3 18:45:05 2025 *
***********************************************************

*pvsViewList = auLvs schematic
*pvsStopList = ("auLvs")
*pvsSimName  = auLvs

*.EXPAND_ON_M_FACTOR
*.MEGA

.subckt NOT A Out Vdd Vss
*PVSCELL netlisted from Group2_VLSI_EE5900 NOT schematic
  MNM0 Out A Vss Vss nfet_01v8 m=1 l=150n w=420n
  MPM0 Out A Vdd Vdd pfet_01v8 m=1 l=150n w=550n
.ends NOT

.subckt NAND A B Out Vdd Vss
*PVSCELL netlisted from Group2_VLSI_EE5900 NAND schematic
  MNM0 Out A net1 Vss nfet_01v8 m=1 l=150n w=420n
  MNM1 net1 B Vss Vss nfet_01v8 m=1 l=150n w=420n
  MPM0 Out A Vdd Vdd pfet_01v8 m=1 l=150n w=550n
  MPM1 Out B Vdd Vdd pfet_01v8 m=1 l=150n w=550n
.ends NAND

.subckt AND A B Out Vdd Vss
*PVSCELL netlisted from Group2_VLSI_EE5900 AND schematic
  XI0 NAND $PINS A=A B=B Out=net6 Vdd=Vdd Vss=Vss
  XI1 NOT $PINS A=net6 Out=Out Vdd=Vdd Vss=Vss
.ends AND

.subckt 1to2_demux D S0 Vdd Y0 Y1 gnd
*PVSCELL netlisted from Group2_VLSI_EE5900 1to2_demux schematic
  XI0 AND $PINS A=net2 B=D Out=Y0 Vdd=Vdd Vss=gnd
  XI1 AND $PINS A=net7 B=D Out=Y1 Vdd=Vdd Vss=gnd
  XI2 NOT $PINS A=net7 Out=net2 Vdd=Vdd Vss=gnd
  XI3 NOT $PINS A=S0 Out=net7 Vdd=Vdd Vss=gnd
.ends 1to2_demux

***********************************************************
*             Completed at Dec  3 18:45:05 2025           *
***********************************************************
