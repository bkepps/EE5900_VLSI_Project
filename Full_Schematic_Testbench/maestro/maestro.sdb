ADE simulation setup
Run mode: Single Run, Sweeps and Corners
Tests:
  Group2_VLSI_EE5900_Full_Schematic_Testbench_1: Group2_VLSI_EE5900/Full_Schematic_Testbench/schematic, simulator spectre
