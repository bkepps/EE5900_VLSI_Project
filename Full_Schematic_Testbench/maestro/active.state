ADE simulation setup
Test Group2_VLSI_EE5900_Full_Schematic_Testbench_1: Group2_VLSI_EE5900/Full_Schematic_Testbench/schematic, simulator spectre
  Models: /opt/cadence-suite/sky130_release_0.0.4/libs/sky130_fd_pr_main/../../models/sky130.lib.spice[tt], /opt/cadence-suite/ncsu/models/spectre/nom/ami06N.m, /opt/cadence-suite/ncsu/models/spectre/nom/ami06P.m, /opt/cadence-suite/ncsu/models/spectre/nom/ami16N.m, /opt/cadence-suite/ncsu/models/spectre/nom/ami16P.m, /opt/cadence-suite/ncsu/models/spectre/nom/hp10N.m, /opt/cadence-suite/ncsu/models/spectre/nom/hp10P.m, /opt/cadence-suite/ncsu/models/spectre/nom/hp14tbN.m, /opt/cadence-suite/ncsu/models/spectre/nom/hp14tbP.m, /opt/cadence-suite/ncsu/models/spectre/nom/tsmc35N.m.n88y, /opt/cadence-suite/ncsu/models/spectre/nom/tsmc35P.m.n88y
  Temperature: 27
  Analysis tran: stop=320n errpreset=moderate
  Signals: /A<3>, /A<2>, /A<1>, /A<0>, /B<3>, /B<2>, /B<1>, /B<0>, /Control<3>, /Control<2>, /Control<1>, /Control<0>, /Out<3>, /Out<2>, /Out<1>, /Out<0>, /clk
Run mode: Single Run, Sweeps and Corners
