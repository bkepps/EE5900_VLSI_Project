ADE simulation setup
Run mode: Single Run, Sweeps and Corners
Tests:
  Group2_VLSI_EE5900_1-Bit_FullAdder_Testbench_1: Group2_VLSI_EE5900/1-Bit_FullAdder_Testbench/schematic, simulator spectre
