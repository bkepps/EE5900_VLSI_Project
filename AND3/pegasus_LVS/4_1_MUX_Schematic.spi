* +++++++++++++++++++++++++++++++++++++++++++++++++++++++++ *
* CDL Netlist:                                              *
*                                                           *
* Cell Name  : 4_1_MUX_Schematic                            *
* Netlisted  : Sun Dec  7 15:12:37 2025                     *
* Pegasus Version: 23.14-s006 Thu Jan 25 18:41:38 PST 2024  *
* +++++++++++++++++++++++++++++++++++++++++++++++++++++++++ *
*.LDD
*.DEVTMPLT 0 R(res_generic_m1) met1_res met1(P) met1(N)
*.DEVTMPLT 1 R(res_generic_m2) met2_res met2(P) met2(N)
*.DEVTMPLT 2 R(res_generic_m3) met3_res met3(P) met3(N)
*.DEVTMPLT 3 R(res_generic_m4) met4_res met4(P) met4(N)
*.DEVTMPLT 4 R(res_generic_m5) met5_res met5(P) met5(N)
*.DEVTMPLT 5 R(RES_GENERIC_ND) diff_res np_term(P) np_term(N)
*.DEVTMPLT 6 R(RES_GENERIC_PD) diff_res pp_term(P) pp_term(N)
*.DEVTMPLT 7 MN(nfet_01v8) nfet_01v8_rec nSourceDrain(D) nfet(G) nSourceDrain(S) pwell(B)
*.DEVTMPLT 8 MP(pfet_01v8) pfet_01v8_rec pSourceDrain(D) pfet(G) pSourceDrain(S) nwell(B)

* +++++++++++++++++++++++++++++++++++++++++++++++++++++++++ *
* Sub cell: pfet_01v8_CDNS_765138355383                     *
* +++++++++++++++++++++++++++++++++++++++++++++++++++++++++ *
.subckt pfet_01v8_CDNS_765138355383 1 2 3
** N=5 EP=3 FDC=1
M0 2 3 1 1 pfet_01v8 L=1.5e-07 W=5.5e-07 $X=0 $Y=0 $dt=8
.ends pfet_01v8_CDNS_765138355383

* +++++++++++++++++++++++++++++++++++++++++++++++++++++++++ *
* Sub cell: NOT                                             *
* +++++++++++++++++++++++++++++++++++++++++++++++++++++++++ *
.subckt NOT 1 2 4
** N=4 EP=3 FDC=1
X5 2 4 1 pfet_01v8_CDNS_765138355383 $T=710 1880 0 0 $X=265 $Y=1700
.ends NOT

* +++++++++++++++++++++++++++++++++++++++++++++++++++++++++ *
* Sub cell: nfet_01v8_CDNS_765138355385                     *
* +++++++++++++++++++++++++++++++++++++++++++++++++++++++++ *
.subckt nfet_01v8_CDNS_765138355385 1 2 3 4
** N=6 EP=4 FDC=1
M0 1 4 2 3 nfet_01v8 L=1.5e-07 W=4.2e-07 $X=0 $Y=0 $dt=7
.ends nfet_01v8_CDNS_765138355385

* +++++++++++++++++++++++++++++++++++++++++++++++++++++++++ *
* Sub cell: nfet_01v8_CDNS_765138355386                     *
* +++++++++++++++++++++++++++++++++++++++++++++++++++++++++ *
.subckt nfet_01v8_CDNS_765138355386 1 2 3
** N=4 EP=3 FDC=1
M0 2 3 1 1 nfet_01v8 L=1.5e-07 W=4.2e-07 $X=0 $Y=0 $dt=7
.ends nfet_01v8_CDNS_765138355386

* +++++++++++++++++++++++++++++++++++++++++++++++++++++++++ *
* Sub cell: pfet_01v8_CDNS_765138355387                     *
* +++++++++++++++++++++++++++++++++++++++++++++++++++++++++ *
.subckt pfet_01v8_CDNS_765138355387 1 2 3
** N=5 EP=3 FDC=1
M0 2 3 1 1 pfet_01v8 L=1.5e-07 W=5.5e-07 $X=0 $Y=0 $dt=8
.ends pfet_01v8_CDNS_765138355387

* +++++++++++++++++++++++++++++++++++++++++++++++++++++++++ *
* Sub cell: pfet_01v8_CDNS_765138355388                     *
* +++++++++++++++++++++++++++++++++++++++++++++++++++++++++ *
.subckt pfet_01v8_CDNS_765138355388 1 2 3
** N=5 EP=3 FDC=1
M0 1 3 2 2 pfet_01v8 L=1.5e-07 W=5.5e-07 $X=0 $Y=0 $dt=8
.ends pfet_01v8_CDNS_765138355388

* +++++++++++++++++++++++++++++++++++++++++++++++++++++++++ *
* Sub cell: NAND                                            *
* +++++++++++++++++++++++++++++++++++++++++++++++++++++++++ *
.subckt NAND 1 2 3 4 5
** N=6 EP=5 FDC=4
X5 5 6 4 1 nfet_01v8_CDNS_765138355385 $T=1430 1420 0 180 $X=875 $Y=220
X6 4 6 2 nfet_01v8_CDNS_765138355386 $T=1790 1420 0 180 $X=1525 $Y=850
X7 3 5 1 pfet_01v8_CDNS_765138355387 $T=850 2510 0 0 $X=405 $Y=2330
X8 5 3 2 pfet_01v8_CDNS_765138355388 $T=1430 3060 0 180 $X=1045 $Y=2330
.ends NAND

* +++++++++++++++++++++++++++++++++++++++++++++++++++++++++ *
* Sub cell: AND                                             *
* +++++++++++++++++++++++++++++++++++++++++++++++++++++++++ *
.subckt AND 1 2 3 4 5 6
** N=6 EP=6 FDC=5
X0 1 4 6 NOT $T=2360 0 0 0 $X=2360 $Y=0
X1 3 2 4 5 1 NAND $T=0 0 0 0 $X=0 $Y=0
.ends AND

* +++++++++++++++++++++++++++++++++++++++++++++++++++++++++ *
* Sub cell: AND3                                            *
* +++++++++++++++++++++++++++++++++++++++++++++++++++++++++ *
.subckt AND3 Vss 2 C B Vdd A Vout
** N=9 EP=7 FDC=11
X0 8 B A Vdd Vss 9 AND $T=0 0 0 0 $X=0 $Y=0
X1 2 C 9 Vdd Vss Vout AND $T=4150 0 0 0 $X=4150 $Y=0
M0 9 8 Vss Vss nfet_01v8 L=1.5e-07 W=4.2e-07 $X=3070 $Y=650 $dt=7
.ends AND3

* +++++++++++++++++++++++++++++++++++++++++++++++++++++++++ *
* Sub cell: nfet_01v8_CDNS_765138355389                     *
* +++++++++++++++++++++++++++++++++++++++++++++++++++++++++ *
.subckt nfet_01v8_CDNS_765138355389 1 2 3
** N=4 EP=3 FDC=1
M0 2 3 1 1 nfet_01v8 L=1.5e-07 W=4.2e-07 $X=0 $Y=0 $dt=7
.ends nfet_01v8_CDNS_765138355389

* +++++++++++++++++++++++++++++++++++++++++++++++++++++++++ *
* Sub cell: pfet_01v8_CDNS_7651383553810                    *
* +++++++++++++++++++++++++++++++++++++++++++++++++++++++++ *
.subckt pfet_01v8_CDNS_7651383553810 1 2 3 4
** N=5 EP=4 FDC=1
M0 2 3 1 4 pfet_01v8 L=1.5e-07 W=5.5e-07 $X=0 $Y=0 $dt=8
.ends pfet_01v8_CDNS_7651383553810

* +++++++++++++++++++++++++++++++++++++++++++++++++++++++++ *
* Sub cell: pfet_01v8_CDNS_7651383553811                    *
* +++++++++++++++++++++++++++++++++++++++++++++++++++++++++ *
.subckt pfet_01v8_CDNS_7651383553811 1 2 3
** N=4 EP=3 FDC=1
M0 2 3 1 1 pfet_01v8 L=1.5e-07 W=5.5e-07 $X=0 $Y=0 $dt=8
.ends pfet_01v8_CDNS_7651383553811

* +++++++++++++++++++++++++++++++++++++++++++++++++++++++++ *
* Sub cell: nfet_01v8_CDNS_7651383553812                    *
* +++++++++++++++++++++++++++++++++++++++++++++++++++++++++ *
.subckt nfet_01v8_CDNS_7651383553812 1 2 3
** N=5 EP=3 FDC=1
M0 2 3 1 1 nfet_01v8 L=1.5e-07 W=4.2e-07 $X=0 $Y=0 $dt=7
.ends nfet_01v8_CDNS_7651383553812

* +++++++++++++++++++++++++++++++++++++++++++++++++++++++++ *
* Sub cell: NOR                                             *
* +++++++++++++++++++++++++++++++++++++++++++++++++++++++++ *
.subckt NOR 1 2 3 4 5
** N=6 EP=5 FDC=4
X5 1 5 3 nfet_01v8_CDNS_765138355389 $T=1300 1370 0 180 $X=1085 $Y=800
X6 6 5 2 4 pfet_01v8_CDNS_7651383553810 $T=1300 3010 0 180 $X=705 $Y=2280
X7 4 6 3 pfet_01v8_CDNS_7651383553811 $T=1660 3010 0 180 $X=1225 $Y=2280
X8 1 5 2 nfet_01v8_CDNS_7651383553812 $T=720 950 0 0 $X=315 $Y=800
.ends NOR

* +++++++++++++++++++++++++++++++++++++++++++++++++++++++++ *
* Sub cell: OR4                                             *
* +++++++++++++++++++++++++++++++++++++++++++++++++++++++++ *
.subckt OR4 2 3 4 5 6 7
** N=12 EP=6 FDC=18
X4 9 7 10 NOT $T=2350 580 0 0 $X=2350 $Y=580
X5 11 7 8 NOT $T=2350 6990 1 0 $X=2350 $Y=3630
X6 12 7 1 NOT $T=6060 800 0 0 $X=6060 $Y=800
X7 2 6 3 7 9 NOR $T=0 0 0 0 $X=0 $Y=0
X8 2 5 4 7 11 NOR $T=0 7560 1 0 $X=0 $Y=3560
X9 2 10 8 7 12 NOR $T=3710 420 0 0 $X=3710 $Y=420
M0 10 9 2 2 nfet_01v8 L=1.5e-07 W=4.2e-07 $X=3060 $Y=1230 $dt=7
M1 8 11 2 2 nfet_01v8 L=1.5e-07 W=4.2e-07 $X=3060 $Y=5920 $dt=7
M2 1 12 2 2 nfet_01v8 L=1.5e-07 W=4.2e-07 $X=6770 $Y=1450 $dt=7
.ends OR4

* +++++++++++++++++++++++++++++++++++++++++++++++++++++++++ *
* Sub cell: 4_1_MUX_Schematic                               *
* +++++++++++++++++++++++++++++++++++++++++++++++++++++++++ *
.subckt 4_1_MUX_Schematic
** N=19 EP=0 FDC=70
X29 1 5 3 NOT $T=430 13610 0 0 $X=430 $Y=13610
X30 2 5 4 NOT $T=3290 13610 0 0 $X=3290 $Y=13610
X31 6 10 2 1 5 11 7 AND3 $T=5630 100 0 0 $X=5630 $Y=100
X32 6 12 4 1 5 13 8 AND3 $T=5630 4380 0 0 $X=5630 $Y=4380
X33 6 14 2 3 5 15 16 AND3 $T=5630 8690 0 0 $X=5630 $Y=8690
X34 6 17 4 3 5 9 18 AND3 $T=5630 12960 0 0 $X=5630 $Y=12960
X35 6 7 16 18 8 5 OR4 $T=15100 9410 0 0 $X=15100 $Y=9410
M0 3 1 6 6 nfet_01v8 L=1.5e-07 W=4.2e-07 $X=1140 $Y=14260 $dt=7
M1 4 2 6 6 nfet_01v8 L=1.5e-07 W=4.2e-07 $X=4000 $Y=14260 $dt=7
M2 7 10 6 6 nfet_01v8 L=1.5e-07 W=4.2e-07 $X=12850 $Y=750 $dt=7
M3 16 14 6 6 nfet_01v8 L=1.5e-07 W=4.2e-07 $X=12850 $Y=9340 $dt=7
M4 18 17 6 6 nfet_01v8 L=1.5e-07 W=4.2e-07 $X=12850 $Y=13610 $dt=7
M5 8 12 6 5 pfet_01v8 L=1.5e-07 W=4.2e-07 $X=12850 $Y=5030 $dt=8
.ends 4_1_MUX_Schematic
