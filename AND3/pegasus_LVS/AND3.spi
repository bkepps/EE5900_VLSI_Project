* +++++++++++++++++++++++++++++++++++++++++++++++++++++++++ *
* CDL Netlist:                                              *
*                                                           *
* Cell Name  : AND3                                         *
* Netlisted  : Sun Dec  7 14:47:42 2025                     *
* Pegasus Version: 23.14-s006 Thu Jan 25 18:41:38 PST 2024  *
* +++++++++++++++++++++++++++++++++++++++++++++++++++++++++ *
*.LDD
*.DEVTMPLT 0 R(res_generic_m1) met1_res met1(P) met1(N)
*.DEVTMPLT 1 R(res_generic_m2) met2_res met2(P) met2(N)
*.DEVTMPLT 2 R(res_generic_m3) met3_res met3(P) met3(N)
*.DEVTMPLT 3 R(res_generic_m4) met4_res met4(P) met4(N)
*.DEVTMPLT 4 R(res_generic_m5) met5_res met5(P) met5(N)
*.DEVTMPLT 5 R(RES_GENERIC_ND) diff_res np_term(P) np_term(N)
*.DEVTMPLT 6 R(RES_GENERIC_PD) diff_res pp_term(P) pp_term(N)
*.DEVTMPLT 7 MN(nfet_01v8) nfet_01v8_rec nSourceDrain(D) nfet(G) nSourceDrain(S) pwell(B)
*.DEVTMPLT 8 MP(pfet_01v8) pfet_01v8_rec pSourceDrain(D) pfet(G) pSourceDrain(S) nwell(B)

* +++++++++++++++++++++++++++++++++++++++++++++++++++++++++ *
* Sub cell: pfet_01v8_CDNS_765136860563                     *
* +++++++++++++++++++++++++++++++++++++++++++++++++++++++++ *
.subckt pfet_01v8_CDNS_765136860563 1 2 3
** N=5 EP=3 FDC=1
M0 2 3 1 1 pfet_01v8 L=1.5e-07 W=5.5e-07 $X=0 $Y=0 $dt=8
.ends pfet_01v8_CDNS_765136860563

* +++++++++++++++++++++++++++++++++++++++++++++++++++++++++ *
* Sub cell: nfet_01v8_CDNS_765136860564                     *
* +++++++++++++++++++++++++++++++++++++++++++++++++++++++++ *
.subckt nfet_01v8_CDNS_765136860564 1 2 3
** N=5 EP=3 FDC=1
M0 2 3 1 1 nfet_01v8 L=1.5e-07 W=4.2e-07 $X=0 $Y=0 $dt=7
.ends nfet_01v8_CDNS_765136860564

* +++++++++++++++++++++++++++++++++++++++++++++++++++++++++ *
* Sub cell: NOT                                             *
* +++++++++++++++++++++++++++++++++++++++++++++++++++++++++ *
.subckt NOT 1 2 3 4
** N=6 EP=4 FDC=2
X3 1 4 3 pfet_01v8_CDNS_765136860563 $T=710 1880 0 0 $X=265 $Y=1700
X4 2 4 3 nfet_01v8_CDNS_765136860564 $T=710 650 0 0 $X=305 $Y=500
.ends NOT

* +++++++++++++++++++++++++++++++++++++++++++++++++++++++++ *
* Sub cell: nfet_01v8_CDNS_765136860565                     *
* +++++++++++++++++++++++++++++++++++++++++++++++++++++++++ *
.subckt nfet_01v8_CDNS_765136860565 1 2 3 4
** N=6 EP=4 FDC=1
M0 1 4 2 3 nfet_01v8 L=1.5e-07 W=4.2e-07 $X=0 $Y=0 $dt=7
.ends nfet_01v8_CDNS_765136860565

* +++++++++++++++++++++++++++++++++++++++++++++++++++++++++ *
* Sub cell: nfet_01v8_CDNS_765136860566                     *
* +++++++++++++++++++++++++++++++++++++++++++++++++++++++++ *
.subckt nfet_01v8_CDNS_765136860566 1 2 3
** N=4 EP=3 FDC=1
M0 2 3 1 1 nfet_01v8 L=1.5e-07 W=4.2e-07 $X=0 $Y=0 $dt=7
.ends nfet_01v8_CDNS_765136860566

* +++++++++++++++++++++++++++++++++++++++++++++++++++++++++ *
* Sub cell: pfet_01v8_CDNS_765136860567                     *
* +++++++++++++++++++++++++++++++++++++++++++++++++++++++++ *
.subckt pfet_01v8_CDNS_765136860567 1 2 3
** N=5 EP=3 FDC=1
M0 2 3 1 1 pfet_01v8 L=1.5e-07 W=5.5e-07 $X=0 $Y=0 $dt=8
.ends pfet_01v8_CDNS_765136860567

* +++++++++++++++++++++++++++++++++++++++++++++++++++++++++ *
* Sub cell: pfet_01v8_CDNS_765136860568                     *
* +++++++++++++++++++++++++++++++++++++++++++++++++++++++++ *
.subckt pfet_01v8_CDNS_765136860568 1 2 3
** N=5 EP=3 FDC=1
M0 1 3 2 2 pfet_01v8 L=1.5e-07 W=5.5e-07 $X=0 $Y=0 $dt=8
.ends pfet_01v8_CDNS_765136860568

* +++++++++++++++++++++++++++++++++++++++++++++++++++++++++ *
* Sub cell: AND                                             *
* +++++++++++++++++++++++++++++++++++++++++++++++++++++++++ *
.subckt AND 1 2 3 4 5
** N=7 EP=5 FDC=6
X5 3 4 6 5 NOT $T=2360 0 0 0 $X=2360 $Y=0
X6 6 7 4 1 nfet_01v8_CDNS_765136860565 $T=1430 1420 0 180 $X=875 $Y=220
X7 4 7 2 nfet_01v8_CDNS_765136860566 $T=1790 1420 0 180 $X=1525 $Y=850
X8 3 6 1 pfet_01v8_CDNS_765136860567 $T=850 2510 0 0 $X=405 $Y=2330
X9 6 3 2 pfet_01v8_CDNS_765136860568 $T=1430 3060 0 180 $X=1045 $Y=2330
.ends AND

* +++++++++++++++++++++++++++++++++++++++++++++++++++++++++ *
* Sub cell: AND3                                            *
* +++++++++++++++++++++++++++++++++++++++++++++++++++++++++ *
.subckt AND3 A B C Vdd Vout Vss
** N=7 EP=6 FDC=12
X0 A B Vdd Vss 5 AND $T=0 0 0 0 $X=0 $Y=0
X1 5 C Vdd Vss Vout AND $T=4150 0 0 0 $X=4150 $Y=0
.ends AND3
