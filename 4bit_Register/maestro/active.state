ADE simulation setup
Test Group2_VLSI_EE5900_4bit_Register_1: Group2_VLSI_EE5900/4bit_Register/schematic, simulator spectre
  Models: /opt/cadence-suite/sky130_release_0.0.4/libs/sky130_fd_pr_main/../../models/sky130.lib.spice[tt]
  Temperature: 27
Run mode: Single Run, Sweeps and Corners
