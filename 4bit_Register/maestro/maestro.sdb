ADE simulation setup
Run mode: Single Run, Sweeps and Corners
Tests:
  Group2_VLSI_EE5900_4bit_Register_1: Group2_VLSI_EE5900/4bit_Register/schematic, simulator spectre
