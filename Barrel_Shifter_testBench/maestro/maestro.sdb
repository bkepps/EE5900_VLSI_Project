ADE simulation setup
Run mode: Single Run, Sweeps and Corners
Tests:
  Group2_VLSI_EE5900_Barrel_Shifter_testBench_1: Group2_VLSI_EE5900/Barrel_Shifter_testBench/schematic, simulator spectre
