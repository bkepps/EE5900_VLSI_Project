ADE simulation setup
Test Group2_VLSI_EE5900_Barrel_Shifter_testBench_1: Group2_VLSI_EE5900/Barrel_Shifter_testBench/schematic, simulator spectre
  Models: /opt/cadence-suite/sky130_release_0.0.4/libs/sky130_fd_pr_main/../../models/sky130.lib.spice[tt]
  Temperature: 27
  Analysis tran: stop=200n
  Signals: /S0, /S1, /W0, /W1, /W2, /W3, /Y0, /Y1, /Y2, /Y3
Run mode: Single Run, Sweeps and Corners
