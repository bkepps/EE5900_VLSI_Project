ADE simulation setup
Test Group2_VLSI_EE5900_4_1_MUX_TestBench_1: Group2_VLSI_EE5900/4_1_MUX_TestBench/schematic, simulator spectre
  Models: /opt/cadence-suite/sky130_release_0.0.4/libs/sky130_fd_pr_main/../../models/sky130.lib.spice[tt]
  Temperature: 27
  Analysis tran: stop=200n errpreset=moderate
  Signals: /net6, /net7, /A, /B, /C, /D, /Vout
Run mode: Single Run, Sweeps and Corners
