ADE simulation setup
Run mode: Single Run, Sweeps and Corners
Tests:
  Group2_VLSI_EE5900_4_1_MUX_TestBench_1: Group2_VLSI_EE5900/4_1_MUX_TestBench/schematic, simulator spectre
