ADE simulation setup
Test Progress_Main_VLSI_LIbrary_SKywater_mux_test_1: Progress_Main_VLSI_LIbrary_SKywater/mux_test/schematic, simulator spectre
  Models: /opt/cadence-suite/sky130_release_0.0.4/libs/sky130_fd_pr_main/../../models/sky130.lib.spice[tt]
  Temperature: 27
  Analysis tran: stop=200n errpreset=moderate
  Signals: /D0, /D1, /D2, /D3, /D4, /D5, /D6, /D7, /S0, /S1, /S2, /Y
Run mode: Single Run, Sweeps and Corners
