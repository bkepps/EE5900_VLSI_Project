ADE simulation setup
Run mode: Single Run, Sweeps and Corners
Tests:
  Progress_Main_VLSI_LIbrary_SKywater_mux_test_1: Progress_Main_VLSI_LIbrary_SKywater/mux_test/schematic, simulator spectre
