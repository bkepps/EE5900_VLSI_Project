ADE simulation setup
Test Progress_Main_VLSI_LIbrary_SKywater_AND4_testBench_1: Progress_Main_VLSI_LIbrary_SKywater/AND4_testBench/schematic, simulator spectre
  Models: /opt/cadence-suite/sky130_release_0.0.4/libs/sky130_fd_pr_main/../../models/sky130.lib.spice[tt]
  Temperature: 27
  Analysis tran: stop=200n errpreset=moderate
  Signals: /A, /B, /C, /D, /Vout
Run mode: Single Run, Sweeps and Corners
