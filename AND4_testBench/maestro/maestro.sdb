ADE simulation setup
Run mode: Single Run, Sweeps and Corners
Tests:
  Progress_Main_VLSI_LIbrary_SKywater_AND4_testBench_1: Group2_VLSI_EE5900/AND4_testBench/schematic, simulator spectre
