ADE simulation setup
Run mode: Single Run, Sweeps and Corners
Tests:
  Group2_VLSI_EE5900_DFlipFlop_Testbench_1: Group2_VLSI_EE5900/DFlipFlop_Testbench/schematic, simulator spectre
