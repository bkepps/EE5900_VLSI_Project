ADE simulation setup
Run mode: Single Run, Sweeps and Corners
Tests:
  Progress_Main_VLSI_LIbrary_SKywater_not_testBench_1: Progress_Main_VLSI_LIbrary_SKywater/not_testBench/schematic, simulator spectre
